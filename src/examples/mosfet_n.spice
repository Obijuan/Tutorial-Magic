* NGSPICE file created from mosfet_n.ext - technology: sky130A

.subckt mosfet_n SOURCE GATE VSUBS DRAIN
X0 DRAIN GATE SOURCE VSUBS sky130_fd_pr__nfet_01v8 ad=0.3 pd=2.2 as=0.3 ps=2.2 w=0.6 l=0.2
.ends
